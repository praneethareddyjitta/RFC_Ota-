// Proposed Fully Differential Recycling Folded-Cascode (RFC) OTA
// Technology: Cadence GPDK 180nm (1.8V)
// Reference: MDPI Electronics 2025, 14, 1543

simulator lang=spectre

subckt rfc_ota (inp inm voutp voutm vdd gnd vb1 vb2 vb3 vb4 vb5)

    // =========================================================================
    // 1. TOP PMOS CURRENT SOURCES & TAIL
    // =========================================================================
    // M9, M10: Main pull-up current sources (W = 3u, L = 2u)
    M9  (y1  vb1 vdd vdd) pmos1 w=3.0u l=2.0u m=1
    M10 (y2  vb1 vdd vdd) pmos1 w=3.0u l=2.0u m=1

    // M12: Tail current source for PMOS input stage (W = 1u, L = 0.5u)
    M12 (vs  vb1 vdd vdd) pmos1 w=1.0u l=0.5u m=1

    // =========================================================================
    // 2. COMPLEMENTARY SUBTHRESHOLD INPUT STAGE
    // =========================================================================
    // M1a, M2a: Subthreshold NMOS input pair (W = 15u, L = 0.5u)
    M1a (y1  inp s11 gnd) nmos1 w=5.0u l=0.5u m=3
    M2a (y2  inm s11 gnd) nmos1 w=5.0u l=0.5u m=3

    // M1b, M2b: Subthreshold PMOS input pair (W = 30u, L = 0.5u)
    M1b (z1  inp vs  vs ) pmos1 w=5.0u l=0.5u m=6
    M2b (z2  inm vs  vs ) pmos1 w=5.0u l=0.5u m=6

    // =========================================================================
    // 3. FOLDED CASCODE PMOS BRANCHES
    // =========================================================================
    // M3a, M4a: Path 1 PMOS Cascodes (W = 20u, L = 2u)
    M3a (voutm vb2 y1 vdd) pmos1 w=5.0u l=2.0u m=4
    M4a (voutp vb2 y2 vdd) pmos1 w=5.0u l=2.0u m=4

    // M3b, M4b: Path 2 PMOS Cascodes (W = 20u, L = 2u)
    M3b (node_x    vb4 z1 vdd) pmos1 w=5.0u l=2.0u m=4
    M4b (node_xbar vb4 z2 vdd) pmos1 w=5.0u l=2.0u m=4

    // =========================================================================
    // 4. RECYCLING CASCODE LOADS & POSITIVE FEEDBACK MIRRORS
    // =========================================================================
    // OUTPUT BRANCH (Ratio k = 4/3): M5a, M6a (20u/2u), M7a, M8a (60u/10u)
    M5a (voutm vb3 s5a gnd) nmos1 w=5.0u l=2.0u m=4
    M7a (s5a   node_x gnd gnd) nmos1 w=7.5u l=10.0u m=8

    M6a (voutp vb3 s6a gnd) nmos1 w=5.0u l=2.0u m=4
    M8a (s6a   node_xbar gnd gnd) nmos1 w=7.5u l=10.0u m=8

    // DIODE-CONNECTED BRANCH (Ratio 1 = 3/3): M5c, M6c (15u/2u), M7c, M8c (45u/10u)
    M5c (node_x    vb5 s5c gnd) nmos1 w=5.0u l=2.0u m=3
    M7c (s5c       node_x gnd gnd) nmos1 w=7.5u l=10.0u m=6

    M6c (node_xbar vb5 s6c gnd) nmos1 w=5.0u l=2.0u m=3
    M8c (s6c       node_xbar gnd gnd) nmos1 w=7.5u l=10.0u m=6

    // CROSS-COUPLED POSITIVE FEEDBACK BRANCH (Ratio m = 1/3):
    // M5b, M6b (5u/2u), M7b, M8b (15u/10u)
    M5b (node_x    vb3 s5b gnd) nmos1 w=5.0u l=2.0u m=1
    M7b (s5b       node_xbar gnd gnd) nmos1 w=7.5u l=10.0u m=2

    M6b (node_xbar vb3 s6b gnd) nmos1 w=5.0u l=2.0u m=1
    M8b (s6b       node_x    gnd gnd) nmos1 w=7.5u l=10.0u m=2

    // =========================================================================
    // 5. CMFB CIRCUIT (Deep Triode Degeneration)
    // =========================================================================
    // M11: NMOS Tail Sink (W = 2u, L = 0.5u)
    M11 (s11 vb3 scmfb gnd) nmos1 w=2.0u l=0.5u m=1

    // M13, M14: Deep Triode Degeneration Devices (W = 2.5u, L = 2u)
    M13 (scmfb voutm gnd gnd) nmos1 w=2.5u l=2.0u m=1
    M14 (scmfb voutp gnd gnd) nmos1 w=2.5u l=2.0u m=1

ends rfc_ota
