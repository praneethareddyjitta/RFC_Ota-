simulator lang=spectre
include "/home/install/FOUNDRY/analog/180nm/models/spectre/gpdk.scs" section=NN
include "rfc_ota_core.scs"

Vdd (vdd 0) vsource dc=1.8
Vgnd (gnd 0) vsource dc=0
Vb1 (vb1 0) vsource dc=1.203
Vb2 (vb2 0) vsource dc=1.273
Vb3 (vb3 0) vsource dc=0.874
Vb4 (vb4 0) vsource dc=0.801
Vb5 (vb5 0) vsource dc=0.752

// Let Vb3_tail be swept to find exact balance Id11 = Id9
parameters vb3_tail=0.78
Vb3_tail (vb3_t 0) vsource dc=vb3_tail

VinP (inp 0) vsource dc=0.9
VinM (inm 0) vsource dc=0.9
VoutP (voutp 0) vsource dc=0.9
VoutM (voutm 0) vsource dc=0.9

// Instantiate OTA with vb3_tail for M11
XOTA (inp inm voutp voutm vdd gnd vb1 vb2 vb3 vb4 vb5) rfc_ota

sweep_vb3 sweep param=vb3_tail start=0.65 stop=0.85 step=0.01 {
    dc_sweep dc
}
save VoutP:p XOTA.M9:d XOTA.M1a:d XOTA.M3a:d XOTA.M5a:d
